$ Spice netlist generated by v2lvs
$ v2021.3_35.19    Wed Sep 1 15:25:12 PDT 2021
.INCLUDE "./spice_delay.inc"
*.BUSDELIMITER [

.SUBCKT hyperbus_delay_welltap in_i out_o delay_i[7] delay_i[6] delay_i[5]
+ delay_i[4] delay_i[3] delay_i[2] delay_i[1] delay_i[0] VSS VDD
XEDGE_WELLTAP_L_0 WELLTAP $PINS VDD=VDD VSS=VSS VNW=VDD VPW=VSS
XEDGE_WELLTAP_L_1 WELLTAP $PINS VDD=VDD VSS=VSS VNW=VDD VPW=VSS
XEDGE_WELLTAP_L_10 WELLTAP $PINS VDD=VDD VSS=VSS VNW=VDD VPW=VSS
XEDGE_WELLTAP_L_2 WELLTAP $PINS VDD=VDD VSS=VSS VNW=VDD VPW=VSS
XEDGE_WELLTAP_L_3 WELLTAP $PINS VDD=VDD VSS=VSS VNW=VDD VPW=VSS
XEDGE_WELLTAP_L_4 WELLTAP $PINS VDD=VDD VSS=VSS VNW=VDD VPW=VSS
XEDGE_WELLTAP_L_5 WELLTAP $PINS VDD=VDD VSS=VSS VNW=VDD VPW=VSS
XEDGE_WELLTAP_L_6 WELLTAP $PINS VDD=VDD VSS=VSS VNW=VDD VPW=VSS
XEDGE_WELLTAP_L_7 WELLTAP $PINS VDD=VDD VSS=VSS VNW=VDD VPW=VSS
XEDGE_WELLTAP_L_8 WELLTAP $PINS VDD=VDD VSS=VSS VNW=VDD VPW=VSS
XEDGE_WELLTAP_L_9 WELLTAP $PINS VDD=VDD VSS=VSS VNW=VDD VPW=VSS
XEDGE_WELLTAP_R_0 WELLTAP $PINS VDD=VDD VSS=VSS VNW=VDD VPW=VSS
XEDGE_WELLTAP_R_1 WELLTAP $PINS VDD=VDD VSS=VSS VNW=VDD VPW=VSS
XEDGE_WELLTAP_R_10 WELLTAP $PINS VDD=VDD VSS=VSS VNW=VDD VPW=VSS
XEDGE_WELLTAP_R_2 WELLTAP $PINS VDD=VDD VSS=VSS VNW=VDD VPW=VSS
XEDGE_WELLTAP_R_3 WELLTAP $PINS VDD=VDD VSS=VSS VNW=VDD VPW=VSS
XEDGE_WELLTAP_R_4 WELLTAP $PINS VDD=VDD VSS=VSS VNW=VDD VPW=VSS
XEDGE_WELLTAP_R_5 WELLTAP $PINS VDD=VDD VSS=VSS VNW=VDD VPW=VSS
XEDGE_WELLTAP_R_6 WELLTAP $PINS VDD=VDD VSS=VSS VNW=VDD VPW=VSS
XEDGE_WELLTAP_R_7 WELLTAP $PINS VDD=VDD VSS=VSS VNW=VDD VPW=VSS
XEDGE_WELLTAP_R_8 WELLTAP $PINS VDD=VDD VSS=VSS VNW=VDD VPW=VSS
XEDGE_WELLTAP_R_9 WELLTAP $PINS VDD=VDD VSS=VSS VNW=VDD VPW=VSS
XFILLER_0_73 FILLER2 $PINS VDD=VDD VSS=VSS
XFILLER_0_75 FILLER1 $PINS VDD=VDD VSS=VSS
XFILLER_10_22 FILLER1 $PINS VDD=VDD VSS=VSS
XFILLER_10_26 FILLER2 $PINS VDD=VDD VSS=VSS
XFILLER_10_3 FILLER1 $PINS VDD=VDD VSS=VSS
XFILLER_10_9 FILLER1 $PINS VDD=VDD VSS=VSS
XFILLER_1_73 FILLER2 $PINS VDD=VDD VSS=VSS
XFILLER_1_75 FILLER1 $PINS VDD=VDD VSS=VSS
XFILLER_2_73 FILLER2 $PINS VDD=VDD VSS=VSS
XFILLER_2_75 FILLER1 $PINS VDD=VDD VSS=VSS
XFILLER_4_73 FILLER2 $PINS VDD=VDD VSS=VSS
XFILLER_4_75 FILLER1 $PINS VDD=VDD VSS=VSS
XFILLER_6_33 FILLER1 $PINS VDD=VDD VSS=VSS
XFILLER_6_73 FILLER2 $PINS VDD=VDD VSS=VSS
XFILLER_6_75 FILLER1 $PINS VDD=VDD VSS=VSS
XFILLER_7_12 FILLER2 $PINS VDD=VDD VSS=VSS
XFILLER_7_14 FILLER1 $PINS VDD=VDD VSS=VSS
XFILLER_8_25 FILLER2 $PINS VDD=VDD VSS=VSS
XFILLER_8_27 FILLER1 $PINS VDD=VDD VSS=VSS
XFILLER_8_7 FILLER2 $PINS VDD=VDD VSS=VSS
XFILLER_8_9 FILLER1 $PINS VDD=VDD VSS=VSS
XFILLER_9_21 FILLER2 $PINS VDD=VDD VSS=VSS
XFILLER_9_23 FILLER1 $PINS VDD=VDD VSS=VSS
XFILLER_9_3 FILLER2 $PINS VDD=VDD VSS=VSS
XFILLER_9_5 FILLER1 $PINS VDD=VDD VSS=VSS
X_05_ INVX1 $PINS Y=_00_ VSS=VSS A=delay_i[3] VDD=VDD VNW=VDD VPW=VSS
X_06_ AND2X1 $PINS VSS=VSS VDD=VDD B=delay_i[4] A=delay_i[3]
+ Y=\i_dline_16taps.dline_cells[11].genblk1.genblk1.i_dly_cell.sel_i VNW=VDD
+ VPW=VSS
X_07_ OA21X2 $PINS VDD=VDD VSS=VSS C=delay_i[4] B=delay_i[2] A=delay_i[3]
+ Y=\i_dline_16taps.dline_cells[9].genblk1.genblk1.i_dly_cell.sel_i VNW=VDD
+ VPW=VSS
X_08_ NOR2X1 $PINS A=delay_i[3] Y=_01_ B=delay_i[4] VDD=VDD VSS=VSS VNW=VDD
+ VPW=VSS
X_09_ INVX1 $PINS
+ Y=\i_dline_16taps.dline_cells[3].genblk1.genblk1.i_dly_cell.sel_i VSS=VSS
+ A=_01_ VDD=VDD VNW=VDD VPW=VSS
X_10_ NAND2BX1 $PINS B=_01_ VSS=VSS VDD=VDD
+ Y=\i_dline_16taps.dline_cells[1].genblk1.genblk1.i_dly_cell.sel_i AB=delay_i[2]
+ VNW=VDD VPW=VSS
X_11_ NOR2X1 $PINS A=delay_i[1] Y=_02_ B=delay_i[2] VDD=VDD VSS=VSS VNW=VDD
+ VPW=VSS
X_12_ NAND2X1 $PINS A=_01_ B=_02_ VSS=VSS VDD=VDD
+ Y=\i_dline_16taps.dline_cells[0].genblk1.i_dly_cell.sel_i VNW=VDD VPW=VSS
X_13_ NAND2X1 $PINS A=delay_i[1] B=delay_i[2] VSS=VSS VDD=VDD Y=_03_ VNW=VDD
+ VPW=VSS
X_14_ AND2X1 $PINS VSS=VSS VDD=VDD
+ B=\i_dline_16taps.dline_cells[11].genblk1.genblk1.i_dly_cell.sel_i A=delay_i[2]
+ Y=\i_dline_16taps.dline_cells[13].genblk1.genblk1.i_dly_cell.sel_i VNW=VDD
+ VPW=VSS
X_15_ NOR2BX1 $PINS
+ AB=\i_dline_16taps.dline_cells[11].genblk1.genblk1.i_dly_cell.sel_i
+ Y=\i_dline_16taps.dline_cells[14].genblk1.genblk1.i_dly_cell.sel_i B=_03_
+ VDD=VDD VSS=VSS VNW=VDD VPW=VSS
X_16_ AOI2B1X1 $PINS
+ Y=\i_dline_16taps.dline_cells[4].genblk1.genblk1.i_dly_cell.sel_i VSS=VSS
+ VDD=VDD C=_01_ B=_02_ AB=delay_i[4] VNW=VDD VPW=VSS
X_17_ NOR2BX1 $PINS
+ AB=\i_dline_16taps.dline_cells[11].genblk1.genblk1.i_dly_cell.sel_i
+ Y=\i_dline_16taps.dline_cells[12].genblk1.genblk1.i_dly_cell.sel_i B=_02_
+ VDD=VDD VSS=VSS VNW=VDD VPW=VSS
X_18_ AO21X2 $PINS C=delay_i[4]
+ Y=\i_dline_16taps.dline_cells[5].genblk1.genblk1.i_dly_cell.sel_i B=delay_i[2]
+ A=delay_i[3] VDD=VDD VSS=VSS VNW=VDD VPW=VSS
X_19_ NOR2X1 $PINS A=delay_i[5] Y=bypass_coarse B=delay_i[6] VDD=VDD VSS=VSS
+ VNW=VDD VPW=VSS
X_20_ NOR2BX1 $PINS AB=dline_out_noninv Y=coarse_nets[42] B=bypass_coarse
+ VDD=VDD VSS=VSS VNW=VDD VPW=VSS
X_21_ AOI21BX1 $PINS VDD=VDD CB=delay_i[4] B=_02_ A=_00_ VSS=VSS
+ Y=\i_dline_16taps.dline_cells[8].genblk1.genblk1.i_dly_cell.sel_i VNW=VDD
+ VPW=VSS
X_22_ AOI21BX1 $PINS VDD=VDD CB=delay_i[4] B=_03_ A=_00_ VSS=VSS
+ Y=\i_dline_16taps.dline_cells[10].genblk1.genblk1.i_dly_cell.sel_i VNW=VDD
+ VPW=VSS
X_23_ NAND2X1 $PINS A=_01_ B=_03_ VSS=VSS VDD=VDD
+ Y=\i_dline_16taps.dline_cells[2].genblk1.genblk1.i_dly_cell.sel_i VNW=VDD
+ VPW=VSS
X_24_ AOI2B1X1 $PINS
+ Y=\i_dline_16taps.dline_cells[6].genblk1.genblk1.i_dly_cell.sel_i VSS=VSS
+ VDD=VDD C=_01_ B=_03_ AB=delay_i[4] VNW=VDD VPW=VSS
X_25_ BUFX1 $PINS A=delay_i[4] VDD=VDD VSS=VSS
+ Y=\i_dline_16taps.dline_cells[7].genblk1.genblk1.i_dly_cell.sel_i VNW=VDD
+ VPW=VSS
X_26_ TIELO $PINS VDD=VDD VSS=VSS Y=_04_ VNW=VDD VPW=VSS
X_27_ TIELO $PINS VDD=VDD VSS=VSS
+ Y=\i_dline_16taps.dline_cells[15].genblk1.genblk1.i_dly_cell.sel_i VNW=VDD
+ VPW=VSS
Xcoarse_mux_hi MUX2X1 $PINS A0=coarse_nets[0] A1=coarse_nets[20] S0=delay_i[5]
+ VDD=VDD VSS=VSS Y=dline_ret_mux1 VNW=VDD VPW=VSS
Xcoarse_mux_lo MUX2X1 $PINS A0=coarse_nets[42] A1=coarse_nets[21] S0=delay_i[5]
+ VDD=VDD VSS=VSS Y=dline_ret_mux0 VNW=VDD VPW=VSS
Xcoarse_mux_sel MUX2X1 $PINS A0=dline_ret_mux0 A1=dline_ret_mux1 S0=delay_i[6]
+ VDD=VDD VSS=VSS Y=dline_coarse_out VNW=VDD VPW=VSS
X\gen_coarse_lines[0].gen_coarse_cells[0].i_coarse_dly DLY1X2 $PINS
+ A=coarse_nets[42] Y=coarse_nets[43] VDD=VDD VSS=VSS VNW=VDD VPW=VSS
X\gen_coarse_lines[0].gen_coarse_cells[10].i_coarse_dly DLY1X2 $PINS
+ A=coarse_nets[52] Y=coarse_nets[53] VDD=VDD VSS=VSS VNW=VDD VPW=VSS
X\gen_coarse_lines[0].gen_coarse_cells[11].i_coarse_dly DLY1X2 $PINS
+ A=coarse_nets[53] Y=coarse_nets[54] VDD=VDD VSS=VSS VNW=VDD VPW=VSS
X\gen_coarse_lines[0].gen_coarse_cells[12].i_coarse_dly DLY1X2 $PINS
+ A=coarse_nets[54] Y=coarse_nets[55] VDD=VDD VSS=VSS VNW=VDD VPW=VSS
X\gen_coarse_lines[0].gen_coarse_cells[13].i_coarse_dly DLY1X2 $PINS
+ A=coarse_nets[55] Y=coarse_nets[56] VDD=VDD VSS=VSS VNW=VDD VPW=VSS
X\gen_coarse_lines[0].gen_coarse_cells[14].i_coarse_dly DLY1X2 $PINS
+ A=coarse_nets[56] Y=coarse_nets[57] VDD=VDD VSS=VSS VNW=VDD VPW=VSS
X\gen_coarse_lines[0].gen_coarse_cells[15].i_coarse_dly DLY1X2 $PINS
+ A=coarse_nets[57] Y=coarse_nets[58] VDD=VDD VSS=VSS VNW=VDD VPW=VSS
X\gen_coarse_lines[0].gen_coarse_cells[16].i_coarse_dly DLY1X2 $PINS
+ A=coarse_nets[58] Y=coarse_nets[59] VDD=VDD VSS=VSS VNW=VDD VPW=VSS
X\gen_coarse_lines[0].gen_coarse_cells[17].i_coarse_dly DLY1X2 $PINS
+ A=coarse_nets[59] Y=coarse_nets[60] VDD=VDD VSS=VSS VNW=VDD VPW=VSS
X\gen_coarse_lines[0].gen_coarse_cells[18].i_coarse_dly DLY1X2 $PINS
+ A=coarse_nets[60] Y=coarse_nets[61] VDD=VDD VSS=VSS VNW=VDD VPW=VSS
X\gen_coarse_lines[0].gen_coarse_cells[19].i_coarse_dly DLY1X2 $PINS
+ A=coarse_nets[61] Y=coarse_nets[21] VDD=VDD VSS=VSS VNW=VDD VPW=VSS
X\gen_coarse_lines[0].gen_coarse_cells[1].i_coarse_dly DLY1X2 $PINS
+ A=coarse_nets[43] Y=coarse_nets[44] VDD=VDD VSS=VSS VNW=VDD VPW=VSS
X\gen_coarse_lines[0].gen_coarse_cells[2].i_coarse_dly DLY1X2 $PINS
+ A=coarse_nets[44] Y=coarse_nets[45] VDD=VDD VSS=VSS VNW=VDD VPW=VSS
X\gen_coarse_lines[0].gen_coarse_cells[3].i_coarse_dly DLY1X2 $PINS
+ A=coarse_nets[45] Y=coarse_nets[46] VDD=VDD VSS=VSS VNW=VDD VPW=VSS
X\gen_coarse_lines[0].gen_coarse_cells[4].i_coarse_dly DLY1X2 $PINS
+ A=coarse_nets[46] Y=coarse_nets[47] VDD=VDD VSS=VSS VNW=VDD VPW=VSS
X\gen_coarse_lines[0].gen_coarse_cells[5].i_coarse_dly DLY1X2 $PINS
+ A=coarse_nets[47] Y=coarse_nets[48] VDD=VDD VSS=VSS VNW=VDD VPW=VSS
X\gen_coarse_lines[0].gen_coarse_cells[6].i_coarse_dly DLY1X2 $PINS
+ A=coarse_nets[48] Y=coarse_nets[49] VDD=VDD VSS=VSS VNW=VDD VPW=VSS
X\gen_coarse_lines[0].gen_coarse_cells[7].i_coarse_dly DLY1X2 $PINS
+ A=coarse_nets[49] Y=coarse_nets[50] VDD=VDD VSS=VSS VNW=VDD VPW=VSS
X\gen_coarse_lines[0].gen_coarse_cells[8].i_coarse_dly DLY1X2 $PINS
+ A=coarse_nets[50] Y=coarse_nets[51] VDD=VDD VSS=VSS VNW=VDD VPW=VSS
X\gen_coarse_lines[0].gen_coarse_cells[9].i_coarse_dly DLY1X2 $PINS
+ A=coarse_nets[51] Y=coarse_nets[52] VDD=VDD VSS=VSS VNW=VDD VPW=VSS
X\gen_coarse_lines[1].gen_coarse_cells[0].i_coarse_dly DLY1X2 $PINS
+ A=coarse_nets[21] Y=coarse_nets[22] VDD=VDD VSS=VSS VNW=VDD VPW=VSS
X\gen_coarse_lines[1].gen_coarse_cells[10].i_coarse_dly DLY1X2 $PINS
+ A=coarse_nets[31] Y=coarse_nets[32] VDD=VDD VSS=VSS VNW=VDD VPW=VSS
X\gen_coarse_lines[1].gen_coarse_cells[11].i_coarse_dly DLY1X2 $PINS
+ A=coarse_nets[32] Y=coarse_nets[33] VDD=VDD VSS=VSS VNW=VDD VPW=VSS
X\gen_coarse_lines[1].gen_coarse_cells[12].i_coarse_dly DLY1X2 $PINS
+ A=coarse_nets[33] Y=coarse_nets[34] VDD=VDD VSS=VSS VNW=VDD VPW=VSS
X\gen_coarse_lines[1].gen_coarse_cells[13].i_coarse_dly DLY1X2 $PINS
+ A=coarse_nets[34] Y=coarse_nets[35] VDD=VDD VSS=VSS VNW=VDD VPW=VSS
X\gen_coarse_lines[1].gen_coarse_cells[14].i_coarse_dly DLY1X2 $PINS
+ A=coarse_nets[35] Y=coarse_nets[36] VDD=VDD VSS=VSS VNW=VDD VPW=VSS
X\gen_coarse_lines[1].gen_coarse_cells[15].i_coarse_dly DLY1X2 $PINS
+ A=coarse_nets[36] Y=coarse_nets[37] VDD=VDD VSS=VSS VNW=VDD VPW=VSS
X\gen_coarse_lines[1].gen_coarse_cells[16].i_coarse_dly DLY1X2 $PINS
+ A=coarse_nets[37] Y=coarse_nets[38] VDD=VDD VSS=VSS VNW=VDD VPW=VSS
X\gen_coarse_lines[1].gen_coarse_cells[17].i_coarse_dly DLY1X2 $PINS
+ A=coarse_nets[38] Y=coarse_nets[39] VDD=VDD VSS=VSS VNW=VDD VPW=VSS
X\gen_coarse_lines[1].gen_coarse_cells[18].i_coarse_dly DLY1X2 $PINS
+ A=coarse_nets[39] Y=coarse_nets[40] VDD=VDD VSS=VSS VNW=VDD VPW=VSS
X\gen_coarse_lines[1].gen_coarse_cells[19].i_coarse_dly DLY1X2 $PINS
+ A=coarse_nets[40] Y=coarse_nets[0] VDD=VDD VSS=VSS VNW=VDD VPW=VSS
X\gen_coarse_lines[1].gen_coarse_cells[1].i_coarse_dly DLY1X2 $PINS
+ A=coarse_nets[22] Y=coarse_nets[23] VDD=VDD VSS=VSS VNW=VDD VPW=VSS
X\gen_coarse_lines[1].gen_coarse_cells[2].i_coarse_dly DLY1X2 $PINS
+ A=coarse_nets[23] Y=coarse_nets[24] VDD=VDD VSS=VSS VNW=VDD VPW=VSS
X\gen_coarse_lines[1].gen_coarse_cells[3].i_coarse_dly DLY1X2 $PINS
+ A=coarse_nets[24] Y=coarse_nets[25] VDD=VDD VSS=VSS VNW=VDD VPW=VSS
X\gen_coarse_lines[1].gen_coarse_cells[4].i_coarse_dly DLY1X2 $PINS
+ A=coarse_nets[25] Y=coarse_nets[26] VDD=VDD VSS=VSS VNW=VDD VPW=VSS
X\gen_coarse_lines[1].gen_coarse_cells[5].i_coarse_dly DLY1X2 $PINS
+ A=coarse_nets[26] Y=coarse_nets[27] VDD=VDD VSS=VSS VNW=VDD VPW=VSS
X\gen_coarse_lines[1].gen_coarse_cells[6].i_coarse_dly DLY1X2 $PINS
+ A=coarse_nets[27] Y=coarse_nets[28] VDD=VDD VSS=VSS VNW=VDD VPW=VSS
X\gen_coarse_lines[1].gen_coarse_cells[7].i_coarse_dly DLY1X2 $PINS
+ A=coarse_nets[28] Y=coarse_nets[29] VDD=VDD VSS=VSS VNW=VDD VPW=VSS
X\gen_coarse_lines[1].gen_coarse_cells[8].i_coarse_dly DLY1X2 $PINS
+ A=coarse_nets[29] Y=coarse_nets[30] VDD=VDD VSS=VSS VNW=VDD VPW=VSS
X\gen_coarse_lines[1].gen_coarse_cells[9].i_coarse_dly DLY1X2 $PINS
+ A=coarse_nets[30] Y=coarse_nets[31] VDD=VDD VSS=VSS VNW=VDD VPW=VSS
X\gen_coarse_lines[2].gen_coarse_cells[0].i_coarse_dly DLY1X2 $PINS
+ A=coarse_nets[0] Y=coarse_nets[1] VDD=VDD VSS=VSS VNW=VDD VPW=VSS
X\gen_coarse_lines[2].gen_coarse_cells[10].i_coarse_dly DLY1X2 $PINS
+ A=coarse_nets[10] Y=coarse_nets[11] VDD=VDD VSS=VSS VNW=VDD VPW=VSS
X\gen_coarse_lines[2].gen_coarse_cells[11].i_coarse_dly DLY1X2 $PINS
+ A=coarse_nets[11] Y=coarse_nets[12] VDD=VDD VSS=VSS VNW=VDD VPW=VSS
X\gen_coarse_lines[2].gen_coarse_cells[12].i_coarse_dly DLY1X2 $PINS
+ A=coarse_nets[12] Y=coarse_nets[13] VDD=VDD VSS=VSS VNW=VDD VPW=VSS
X\gen_coarse_lines[2].gen_coarse_cells[13].i_coarse_dly DLY1X2 $PINS
+ A=coarse_nets[13] Y=coarse_nets[14] VDD=VDD VSS=VSS VNW=VDD VPW=VSS
X\gen_coarse_lines[2].gen_coarse_cells[14].i_coarse_dly DLY1X2 $PINS
+ A=coarse_nets[14] Y=coarse_nets[15] VDD=VDD VSS=VSS VNW=VDD VPW=VSS
X\gen_coarse_lines[2].gen_coarse_cells[15].i_coarse_dly DLY1X2 $PINS
+ A=coarse_nets[15] Y=coarse_nets[16] VDD=VDD VSS=VSS VNW=VDD VPW=VSS
X\gen_coarse_lines[2].gen_coarse_cells[16].i_coarse_dly DLY1X2 $PINS
+ A=coarse_nets[16] Y=coarse_nets[17] VDD=VDD VSS=VSS VNW=VDD VPW=VSS
X\gen_coarse_lines[2].gen_coarse_cells[17].i_coarse_dly DLY1X2 $PINS
+ A=coarse_nets[17] Y=coarse_nets[18] VDD=VDD VSS=VSS VNW=VDD VPW=VSS
X\gen_coarse_lines[2].gen_coarse_cells[18].i_coarse_dly DLY1X2 $PINS
+ A=coarse_nets[18] Y=coarse_nets[19] VDD=VDD VSS=VSS VNW=VDD VPW=VSS
X\gen_coarse_lines[2].gen_coarse_cells[19].i_coarse_dly DLY1X2 $PINS
+ A=coarse_nets[19] Y=coarse_nets[20] VDD=VDD VSS=VSS VNW=VDD VPW=VSS
X\gen_coarse_lines[2].gen_coarse_cells[1].i_coarse_dly DLY1X2 $PINS
+ A=coarse_nets[1] Y=coarse_nets[2] VDD=VDD VSS=VSS VNW=VDD VPW=VSS
X\gen_coarse_lines[2].gen_coarse_cells[2].i_coarse_dly DLY1X2 $PINS
+ A=coarse_nets[2] Y=coarse_nets[3] VDD=VDD VSS=VSS VNW=VDD VPW=VSS
X\gen_coarse_lines[2].gen_coarse_cells[3].i_coarse_dly DLY1X2 $PINS
+ A=coarse_nets[3] Y=coarse_nets[4] VDD=VDD VSS=VSS VNW=VDD VPW=VSS
X\gen_coarse_lines[2].gen_coarse_cells[4].i_coarse_dly DLY1X2 $PINS
+ A=coarse_nets[4] Y=coarse_nets[5] VDD=VDD VSS=VSS VNW=VDD VPW=VSS
X\gen_coarse_lines[2].gen_coarse_cells[5].i_coarse_dly DLY1X2 $PINS
+ A=coarse_nets[5] Y=coarse_nets[6] VDD=VDD VSS=VSS VNW=VDD VPW=VSS
X\gen_coarse_lines[2].gen_coarse_cells[6].i_coarse_dly DLY1X2 $PINS
+ A=coarse_nets[6] Y=coarse_nets[7] VDD=VDD VSS=VSS VNW=VDD VPW=VSS
X\gen_coarse_lines[2].gen_coarse_cells[7].i_coarse_dly DLY1X2 $PINS
+ A=coarse_nets[7] Y=coarse_nets[8] VDD=VDD VSS=VSS VNW=VDD VPW=VSS
X\gen_coarse_lines[2].gen_coarse_cells[8].i_coarse_dly DLY1X2 $PINS
+ A=coarse_nets[8] Y=coarse_nets[9] VDD=VDD VSS=VSS VNW=VDD VPW=VSS
X\gen_coarse_lines[2].gen_coarse_cells[9].i_coarse_dly DLY1X2 $PINS
+ A=coarse_nets[9] Y=coarse_nets[10] VDD=VDD VSS=VSS VNW=VDD VPW=VSS
Xi_coarse_mux MUX2X2 $PINS A0=dline_coarse_out A1=dline_out_noninv
+ S0=bypass_coarse VDD=VDD VSS=VSS Y=out_o VNW=VDD VPW=VSS
X\i_dline_16taps.dline_cells[0].genblk1.i_dly_cell.gen_alt_cell.i_fwd_gate
+ NOR2X2 $PINS A=in_i
+ Y=\i_dline_16taps.dline_cells[0].genblk1.i_dly_cell.fwd_mux
+ B=\i_dline_16taps.dline_cells[0].genblk1.i_dly_cell.sel_n VDD=VDD VSS=VSS
+ VNW=VDD VPW=VSS
X\i_dline_16taps.dline_cells[0].genblk1.i_dly_cell.gen_alt_cell.i_ret_gate
+ OAI21X2 $PINS A=\i_dline_16taps.dline_cells[0].genblk1.i_dly_cell.sel_i
+ VDD=VDD B=in_i VSS=VSS
+ C=\i_dline_16taps.dline_cells[0].genblk1.i_dly_cell.ret_i Y=dline_out VNW=VDD
+ VPW=VSS
X\i_dline_16taps.dline_cells[0].genblk1.i_dly_cell.i_sel_inv INVX1 $PINS
+ Y=\i_dline_16taps.dline_cells[0].genblk1.i_dly_cell.sel_n VSS=VSS
+ A=\i_dline_16taps.dline_cells[0].genblk1.i_dly_cell.sel_i VDD=VDD VNW=VDD
+ VPW=VSS
X\i_dline_16taps.dline_cells[10].genblk1.genblk1.i_dly_cell.gen_alt_cell.i_fwd_gate
+ NOR2X2 $PINS
+ A=\i_dline_16taps.dline_cells[9].genblk1.genblk1.i_dly_cell.fwd_mux
+ Y=\i_dline_16taps.dline_cells[10].genblk1.genblk1.i_dly_cell.fwd_mux
+ B=\i_dline_16taps.dline_cells[10].genblk1.genblk1.i_dly_cell.sel_n VDD=VDD
+ VSS=VSS VNW=VDD VPW=VSS
X\i_dline_16taps.dline_cells[10].genblk1.genblk1.i_dly_cell.gen_alt_cell.i_ret_gate
+ OAI21X2 $PINS
+ A=\i_dline_16taps.dline_cells[10].genblk1.genblk1.i_dly_cell.sel_i VDD=VDD
+ B=\i_dline_16taps.dline_cells[9].genblk1.genblk1.i_dly_cell.fwd_mux VSS=VSS
+ C=\i_dline_16taps.dline_cells[10].genblk1.genblk1.i_dly_cell.ret_i
+ Y=\i_dline_16taps.dline_cells[10].genblk1.genblk1.i_dly_cell.ret_o VNW=VDD
+ VPW=VSS
X\i_dline_16taps.dline_cells[10].genblk1.genblk1.i_dly_cell.i_sel_inv INVX1
+ $PINS Y=\i_dline_16taps.dline_cells[10].genblk1.genblk1.i_dly_cell.sel_n
+ VSS=VSS A=\i_dline_16taps.dline_cells[10].genblk1.genblk1.i_dly_cell.sel_i
+ VDD=VDD VNW=VDD VPW=VSS
X\i_dline_16taps.dline_cells[11].genblk1.genblk1.i_dly_cell.gen_default_cell.i_fwd_gate
+ NAND2X2 $PINS
+ A=\i_dline_16taps.dline_cells[11].genblk1.genblk1.i_dly_cell.sel_i
+ B=\i_dline_16taps.dline_cells[10].genblk1.genblk1.i_dly_cell.fwd_mux VSS=VSS
+ VDD=VDD Y=\i_dline_16taps.dline_cells[11].genblk1.genblk1.i_dly_cell.fwd_mux
+ VNW=VDD VPW=VSS
X\i_dline_16taps.dline_cells[11].genblk1.genblk1.i_dly_cell.gen_default_cell.i_ret_gate
+ AOI21X2 $PINS
+ A=\i_dline_16taps.dline_cells[10].genblk1.genblk1.i_dly_cell.fwd_mux
+ B=\i_dline_16taps.dline_cells[11].genblk1.genblk1.i_dly_cell.sel_n
+ C=\i_dline_16taps.dline_cells[11].genblk1.genblk1.i_dly_cell.ret_i VDD=VDD
+ VSS=VSS Y=\i_dline_16taps.dline_cells[10].genblk1.genblk1.i_dly_cell.ret_i
+ VNW=VDD VPW=VSS
X\i_dline_16taps.dline_cells[11].genblk1.genblk1.i_dly_cell.i_sel_inv INVX1
+ $PINS Y=\i_dline_16taps.dline_cells[11].genblk1.genblk1.i_dly_cell.sel_n
+ VSS=VSS A=\i_dline_16taps.dline_cells[11].genblk1.genblk1.i_dly_cell.sel_i
+ VDD=VDD VNW=VDD VPW=VSS
X\i_dline_16taps.dline_cells[12].genblk1.genblk1.i_dly_cell.gen_alt_cell.i_fwd_gate
+ NOR2X2 $PINS
+ A=\i_dline_16taps.dline_cells[11].genblk1.genblk1.i_dly_cell.fwd_mux
+ Y=\i_dline_16taps.dline_cells[12].genblk1.genblk1.i_dly_cell.fwd_mux
+ B=\i_dline_16taps.dline_cells[12].genblk1.genblk1.i_dly_cell.sel_n VDD=VDD
+ VSS=VSS VNW=VDD VPW=VSS
X\i_dline_16taps.dline_cells[12].genblk1.genblk1.i_dly_cell.gen_alt_cell.i_ret_gate
+ OAI21X2 $PINS
+ A=\i_dline_16taps.dline_cells[12].genblk1.genblk1.i_dly_cell.sel_i VDD=VDD
+ B=\i_dline_16taps.dline_cells[11].genblk1.genblk1.i_dly_cell.fwd_mux VSS=VSS
+ C=\i_dline_16taps.dline_cells[12].genblk1.genblk1.i_dly_cell.ret_i
+ Y=\i_dline_16taps.dline_cells[11].genblk1.genblk1.i_dly_cell.ret_i VNW=VDD
+ VPW=VSS
X\i_dline_16taps.dline_cells[12].genblk1.genblk1.i_dly_cell.i_sel_inv INVX1
+ $PINS Y=\i_dline_16taps.dline_cells[12].genblk1.genblk1.i_dly_cell.sel_n
+ VSS=VSS A=\i_dline_16taps.dline_cells[12].genblk1.genblk1.i_dly_cell.sel_i
+ VDD=VDD VNW=VDD VPW=VSS
X\i_dline_16taps.dline_cells[13].genblk1.genblk1.i_dly_cell.gen_default_cell.i_fwd_gate
+ NAND2X2 $PINS
+ A=\i_dline_16taps.dline_cells[13].genblk1.genblk1.i_dly_cell.sel_i
+ B=\i_dline_16taps.dline_cells[12].genblk1.genblk1.i_dly_cell.fwd_mux VSS=VSS
+ VDD=VDD Y=\i_dline_16taps.dline_cells[13].genblk1.genblk1.i_dly_cell.fwd_mux
+ VNW=VDD VPW=VSS
X\i_dline_16taps.dline_cells[13].genblk1.genblk1.i_dly_cell.gen_default_cell.i_ret_gate
+ AOI21X2 $PINS
+ A=\i_dline_16taps.dline_cells[12].genblk1.genblk1.i_dly_cell.fwd_mux
+ B=\i_dline_16taps.dline_cells[13].genblk1.genblk1.i_dly_cell.sel_n
+ C=\i_dline_16taps.dline_cells[13].genblk1.genblk1.i_dly_cell.ret_i VDD=VDD
+ VSS=VSS Y=\i_dline_16taps.dline_cells[12].genblk1.genblk1.i_dly_cell.ret_i
+ VNW=VDD VPW=VSS
X\i_dline_16taps.dline_cells[13].genblk1.genblk1.i_dly_cell.i_sel_inv INVX1
+ $PINS Y=\i_dline_16taps.dline_cells[13].genblk1.genblk1.i_dly_cell.sel_n
+ VSS=VSS A=\i_dline_16taps.dline_cells[13].genblk1.genblk1.i_dly_cell.sel_i
+ VDD=VDD VNW=VDD VPW=VSS
X\i_dline_16taps.dline_cells[14].genblk1.genblk1.i_dly_cell.gen_alt_cell.i_fwd_gate
+ NOR2X2 $PINS
+ A=\i_dline_16taps.dline_cells[13].genblk1.genblk1.i_dly_cell.fwd_mux
+ Y=\i_dline_16taps.dline_cells[14].genblk1.genblk1.i_dly_cell.fwd_mux
+ B=\i_dline_16taps.dline_cells[14].genblk1.genblk1.i_dly_cell.sel_n VDD=VDD
+ VSS=VSS VNW=VDD VPW=VSS
X\i_dline_16taps.dline_cells[14].genblk1.genblk1.i_dly_cell.gen_alt_cell.i_ret_gate
+ OAI21X2 $PINS
+ A=\i_dline_16taps.dline_cells[14].genblk1.genblk1.i_dly_cell.sel_i VDD=VDD
+ B=\i_dline_16taps.dline_cells[13].genblk1.genblk1.i_dly_cell.fwd_mux VSS=VSS
+ C=\i_dline_16taps.dline_cells[14].genblk1.genblk1.i_dly_cell.ret_i
+ Y=\i_dline_16taps.dline_cells[13].genblk1.genblk1.i_dly_cell.ret_i VNW=VDD
+ VPW=VSS
X\i_dline_16taps.dline_cells[14].genblk1.genblk1.i_dly_cell.i_sel_inv INVX1
+ $PINS Y=\i_dline_16taps.dline_cells[14].genblk1.genblk1.i_dly_cell.sel_n
+ VSS=VSS A=\i_dline_16taps.dline_cells[14].genblk1.genblk1.i_dly_cell.sel_i
+ VDD=VDD VNW=VDD VPW=VSS
X\i_dline_16taps.dline_cells[15].genblk1.genblk1.i_dly_cell.gen_default_cell.i_fwd_gate
+ NAND2X2 $PINS
+ A=\i_dline_16taps.dline_cells[15].genblk1.genblk1.i_dly_cell.sel_i
+ B=\i_dline_16taps.dline_cells[14].genblk1.genblk1.i_dly_cell.fwd_mux VSS=VSS
+ VDD=VDD Y=\i_dline_16taps.dline_cells[15].genblk1.genblk1.i_dly_cell.fwd_mux
+ VNW=VDD VPW=VSS
X\i_dline_16taps.dline_cells[15].genblk1.genblk1.i_dly_cell.gen_default_cell.i_ret_gate
+ AOI21X2 $PINS
+ A=\i_dline_16taps.dline_cells[14].genblk1.genblk1.i_dly_cell.fwd_mux
+ B=\i_dline_16taps.dline_cells[15].genblk1.genblk1.i_dly_cell.sel_n C=_04_
+ VDD=VDD VSS=VSS
+ Y=\i_dline_16taps.dline_cells[14].genblk1.genblk1.i_dly_cell.ret_i VNW=VDD
+ VPW=VSS
X\i_dline_16taps.dline_cells[15].genblk1.genblk1.i_dly_cell.i_sel_inv INVX1
+ $PINS Y=\i_dline_16taps.dline_cells[15].genblk1.genblk1.i_dly_cell.sel_n
+ VSS=VSS A=\i_dline_16taps.dline_cells[15].genblk1.genblk1.i_dly_cell.sel_i
+ VDD=VDD VNW=VDD VPW=VSS
X\i_dline_16taps.dline_cells[1].genblk1.genblk1.i_dly_cell.gen_default_cell.i_fwd_gate
+ NAND2X2 $PINS
+ A=\i_dline_16taps.dline_cells[1].genblk1.genblk1.i_dly_cell.sel_i
+ B=\i_dline_16taps.dline_cells[0].genblk1.i_dly_cell.fwd_mux VSS=VSS VDD=VDD
+ Y=\i_dline_16taps.dline_cells[1].genblk1.genblk1.i_dly_cell.fwd_mux VNW=VDD
+ VPW=VSS
X\i_dline_16taps.dline_cells[1].genblk1.genblk1.i_dly_cell.gen_default_cell.i_ret_gate
+ AOI21X2 $PINS A=\i_dline_16taps.dline_cells[0].genblk1.i_dly_cell.fwd_mux
+ B=\i_dline_16taps.dline_cells[1].genblk1.genblk1.i_dly_cell.sel_n
+ C=\i_dline_16taps.dline_cells[1].genblk1.genblk1.i_dly_cell.ret_i VDD=VDD
+ VSS=VSS Y=\i_dline_16taps.dline_cells[0].genblk1.i_dly_cell.ret_i VNW=VDD
+ VPW=VSS
X\i_dline_16taps.dline_cells[1].genblk1.genblk1.i_dly_cell.i_sel_inv INVX1
+ $PINS Y=\i_dline_16taps.dline_cells[1].genblk1.genblk1.i_dly_cell.sel_n
+ VSS=VSS A=\i_dline_16taps.dline_cells[1].genblk1.genblk1.i_dly_cell.sel_i
+ VDD=VDD VNW=VDD VPW=VSS
X\i_dline_16taps.dline_cells[2].genblk1.genblk1.i_dly_cell.gen_alt_cell.i_fwd_gate
+ NOR2X2 $PINS
+ A=\i_dline_16taps.dline_cells[1].genblk1.genblk1.i_dly_cell.fwd_mux
+ Y=\i_dline_16taps.dline_cells[2].genblk1.genblk1.i_dly_cell.fwd_mux
+ B=\i_dline_16taps.dline_cells[2].genblk1.genblk1.i_dly_cell.sel_n VDD=VDD
+ VSS=VSS VNW=VDD VPW=VSS
X\i_dline_16taps.dline_cells[2].genblk1.genblk1.i_dly_cell.gen_alt_cell.i_ret_gate
+ OAI21X2 $PINS
+ A=\i_dline_16taps.dline_cells[2].genblk1.genblk1.i_dly_cell.sel_i VDD=VDD
+ B=\i_dline_16taps.dline_cells[1].genblk1.genblk1.i_dly_cell.fwd_mux VSS=VSS
+ C=\i_dline_16taps.dline_cells[2].genblk1.genblk1.i_dly_cell.ret_i
+ Y=\i_dline_16taps.dline_cells[1].genblk1.genblk1.i_dly_cell.ret_i VNW=VDD
+ VPW=VSS
X\i_dline_16taps.dline_cells[2].genblk1.genblk1.i_dly_cell.i_sel_inv INVX1
+ $PINS Y=\i_dline_16taps.dline_cells[2].genblk1.genblk1.i_dly_cell.sel_n
+ VSS=VSS A=\i_dline_16taps.dline_cells[2].genblk1.genblk1.i_dly_cell.sel_i
+ VDD=VDD VNW=VDD VPW=VSS
X\i_dline_16taps.dline_cells[3].genblk1.genblk1.i_dly_cell.gen_default_cell.i_fwd_gate
+ NAND2X2 $PINS
+ A=\i_dline_16taps.dline_cells[3].genblk1.genblk1.i_dly_cell.sel_i
+ B=\i_dline_16taps.dline_cells[2].genblk1.genblk1.i_dly_cell.fwd_mux VSS=VSS
+ VDD=VDD Y=\i_dline_16taps.dline_cells[3].genblk1.genblk1.i_dly_cell.fwd_mux
+ VNW=VDD VPW=VSS
X\i_dline_16taps.dline_cells[3].genblk1.genblk1.i_dly_cell.gen_default_cell.i_ret_gate
+ AOI21X2 $PINS
+ A=\i_dline_16taps.dline_cells[2].genblk1.genblk1.i_dly_cell.fwd_mux
+ B=\i_dline_16taps.dline_cells[3].genblk1.genblk1.i_dly_cell.sel_n
+ C=\i_dline_16taps.dline_cells[3].genblk1.genblk1.i_dly_cell.ret_i VDD=VDD
+ VSS=VSS Y=\i_dline_16taps.dline_cells[2].genblk1.genblk1.i_dly_cell.ret_i
+ VNW=VDD VPW=VSS
X\i_dline_16taps.dline_cells[3].genblk1.genblk1.i_dly_cell.i_sel_inv INVX1
+ $PINS Y=\i_dline_16taps.dline_cells[3].genblk1.genblk1.i_dly_cell.sel_n
+ VSS=VSS A=\i_dline_16taps.dline_cells[3].genblk1.genblk1.i_dly_cell.sel_i
+ VDD=VDD VNW=VDD VPW=VSS
X\i_dline_16taps.dline_cells[4].genblk1.genblk1.i_dly_cell.gen_alt_cell.i_fwd_gate
+ NOR2X2 $PINS
+ A=\i_dline_16taps.dline_cells[3].genblk1.genblk1.i_dly_cell.fwd_mux
+ Y=\i_dline_16taps.dline_cells[4].genblk1.genblk1.i_dly_cell.fwd_mux
+ B=\i_dline_16taps.dline_cells[4].genblk1.genblk1.i_dly_cell.sel_n VDD=VDD
+ VSS=VSS VNW=VDD VPW=VSS
X\i_dline_16taps.dline_cells[4].genblk1.genblk1.i_dly_cell.gen_alt_cell.i_ret_gate
+ OAI21X2 $PINS
+ A=\i_dline_16taps.dline_cells[4].genblk1.genblk1.i_dly_cell.sel_i VDD=VDD
+ B=\i_dline_16taps.dline_cells[3].genblk1.genblk1.i_dly_cell.fwd_mux VSS=VSS
+ C=\i_dline_16taps.dline_cells[4].genblk1.genblk1.i_dly_cell.ret_i
+ Y=\i_dline_16taps.dline_cells[3].genblk1.genblk1.i_dly_cell.ret_i VNW=VDD
+ VPW=VSS
X\i_dline_16taps.dline_cells[4].genblk1.genblk1.i_dly_cell.i_sel_inv INVX1
+ $PINS Y=\i_dline_16taps.dline_cells[4].genblk1.genblk1.i_dly_cell.sel_n
+ VSS=VSS A=\i_dline_16taps.dline_cells[4].genblk1.genblk1.i_dly_cell.sel_i
+ VDD=VDD VNW=VDD VPW=VSS
X\i_dline_16taps.dline_cells[5].genblk1.genblk1.i_dly_cell.gen_default_cell.i_fwd_gate
+ NAND2X2 $PINS
+ A=\i_dline_16taps.dline_cells[5].genblk1.genblk1.i_dly_cell.sel_i
+ B=\i_dline_16taps.dline_cells[4].genblk1.genblk1.i_dly_cell.fwd_mux VSS=VSS
+ VDD=VDD Y=\i_dline_16taps.dline_cells[5].genblk1.genblk1.i_dly_cell.fwd_mux
+ VNW=VDD VPW=VSS
X\i_dline_16taps.dline_cells[5].genblk1.genblk1.i_dly_cell.gen_default_cell.i_ret_gate
+ AOI21X2 $PINS
+ A=\i_dline_16taps.dline_cells[4].genblk1.genblk1.i_dly_cell.fwd_mux
+ B=\i_dline_16taps.dline_cells[5].genblk1.genblk1.i_dly_cell.sel_n
+ C=\i_dline_16taps.dline_cells[5].genblk1.genblk1.i_dly_cell.ret_i VDD=VDD
+ VSS=VSS Y=\i_dline_16taps.dline_cells[4].genblk1.genblk1.i_dly_cell.ret_i
+ VNW=VDD VPW=VSS
X\i_dline_16taps.dline_cells[5].genblk1.genblk1.i_dly_cell.i_sel_inv INVX1
+ $PINS Y=\i_dline_16taps.dline_cells[5].genblk1.genblk1.i_dly_cell.sel_n
+ VSS=VSS A=\i_dline_16taps.dline_cells[5].genblk1.genblk1.i_dly_cell.sel_i
+ VDD=VDD VNW=VDD VPW=VSS
X\i_dline_16taps.dline_cells[6].genblk1.genblk1.i_dly_cell.gen_alt_cell.i_fwd_gate
+ NOR2X2 $PINS
+ A=\i_dline_16taps.dline_cells[5].genblk1.genblk1.i_dly_cell.fwd_mux
+ Y=\i_dline_16taps.dline_cells[6].genblk1.genblk1.i_dly_cell.fwd_mux
+ B=\i_dline_16taps.dline_cells[6].genblk1.genblk1.i_dly_cell.sel_n VDD=VDD
+ VSS=VSS VNW=VDD VPW=VSS
X\i_dline_16taps.dline_cells[6].genblk1.genblk1.i_dly_cell.gen_alt_cell.i_ret_gate
+ OAI21X2 $PINS
+ A=\i_dline_16taps.dline_cells[6].genblk1.genblk1.i_dly_cell.sel_i VDD=VDD
+ B=\i_dline_16taps.dline_cells[5].genblk1.genblk1.i_dly_cell.fwd_mux VSS=VSS
+ C=\i_dline_16taps.dline_cells[6].genblk1.genblk1.i_dly_cell.ret_i
+ Y=\i_dline_16taps.dline_cells[5].genblk1.genblk1.i_dly_cell.ret_i VNW=VDD
+ VPW=VSS
X\i_dline_16taps.dline_cells[6].genblk1.genblk1.i_dly_cell.i_sel_inv INVX1
+ $PINS Y=\i_dline_16taps.dline_cells[6].genblk1.genblk1.i_dly_cell.sel_n
+ VSS=VSS A=\i_dline_16taps.dline_cells[6].genblk1.genblk1.i_dly_cell.sel_i
+ VDD=VDD VNW=VDD VPW=VSS
X\i_dline_16taps.dline_cells[7].genblk1.genblk1.i_dly_cell.gen_default_cell.i_fwd_gate
+ NAND2X2 $PINS
+ A=\i_dline_16taps.dline_cells[7].genblk1.genblk1.i_dly_cell.sel_i
+ B=\i_dline_16taps.dline_cells[6].genblk1.genblk1.i_dly_cell.fwd_mux VSS=VSS
+ VDD=VDD Y=\i_dline_16taps.dline_cells[7].genblk1.genblk1.i_dly_cell.fwd_mux
+ VNW=VDD VPW=VSS
X\i_dline_16taps.dline_cells[7].genblk1.genblk1.i_dly_cell.gen_default_cell.i_ret_gate
+ AOI21X2 $PINS
+ A=\i_dline_16taps.dline_cells[6].genblk1.genblk1.i_dly_cell.fwd_mux
+ B=\i_dline_16taps.dline_cells[7].genblk1.genblk1.i_dly_cell.sel_n
+ C=\i_dline_16taps.dline_cells[7].genblk1.genblk1.i_dly_cell.ret_i VDD=VDD
+ VSS=VSS Y=\i_dline_16taps.dline_cells[6].genblk1.genblk1.i_dly_cell.ret_i
+ VNW=VDD VPW=VSS
X\i_dline_16taps.dline_cells[7].genblk1.genblk1.i_dly_cell.i_sel_inv INVX1
+ $PINS Y=\i_dline_16taps.dline_cells[7].genblk1.genblk1.i_dly_cell.sel_n
+ VSS=VSS A=\i_dline_16taps.dline_cells[7].genblk1.genblk1.i_dly_cell.sel_i
+ VDD=VDD VNW=VDD VPW=VSS
X\i_dline_16taps.dline_cells[8].genblk1.genblk1.i_dly_cell.gen_alt_cell.i_fwd_gate
+ NOR2X2 $PINS
+ A=\i_dline_16taps.dline_cells[7].genblk1.genblk1.i_dly_cell.fwd_mux
+ Y=\i_dline_16taps.dline_cells[8].genblk1.genblk1.i_dly_cell.fwd_mux
+ B=\i_dline_16taps.dline_cells[8].genblk1.genblk1.i_dly_cell.sel_n VDD=VDD
+ VSS=VSS VNW=VDD VPW=VSS
X\i_dline_16taps.dline_cells[8].genblk1.genblk1.i_dly_cell.gen_alt_cell.i_ret_gate
+ OAI21X2 $PINS
+ A=\i_dline_16taps.dline_cells[8].genblk1.genblk1.i_dly_cell.sel_i VDD=VDD
+ B=\i_dline_16taps.dline_cells[7].genblk1.genblk1.i_dly_cell.fwd_mux VSS=VSS
+ C=\i_dline_16taps.dline_cells[8].genblk1.genblk1.i_dly_cell.ret_i
+ Y=\i_dline_16taps.dline_cells[7].genblk1.genblk1.i_dly_cell.ret_i VNW=VDD
+ VPW=VSS
X\i_dline_16taps.dline_cells[8].genblk1.genblk1.i_dly_cell.i_sel_inv INVX1
+ $PINS Y=\i_dline_16taps.dline_cells[8].genblk1.genblk1.i_dly_cell.sel_n
+ VSS=VSS A=\i_dline_16taps.dline_cells[8].genblk1.genblk1.i_dly_cell.sel_i
+ VDD=VDD VNW=VDD VPW=VSS
X\i_dline_16taps.dline_cells[9].genblk1.genblk1.i_dly_cell.gen_default_cell.i_fwd_gate
+ NAND2X2 $PINS
+ A=\i_dline_16taps.dline_cells[9].genblk1.genblk1.i_dly_cell.sel_i
+ B=\i_dline_16taps.dline_cells[8].genblk1.genblk1.i_dly_cell.fwd_mux VSS=VSS
+ VDD=VDD Y=\i_dline_16taps.dline_cells[9].genblk1.genblk1.i_dly_cell.fwd_mux
+ VNW=VDD VPW=VSS
X\i_dline_16taps.dline_cells[9].genblk1.genblk1.i_dly_cell.gen_default_cell.i_ret_gate
+ AOI21X2 $PINS
+ A=\i_dline_16taps.dline_cells[8].genblk1.genblk1.i_dly_cell.fwd_mux
+ B=\i_dline_16taps.dline_cells[9].genblk1.genblk1.i_dly_cell.sel_n
+ C=\i_dline_16taps.dline_cells[10].genblk1.genblk1.i_dly_cell.ret_o VDD=VDD
+ VSS=VSS Y=\i_dline_16taps.dline_cells[8].genblk1.genblk1.i_dly_cell.ret_i
+ VNW=VDD VPW=VSS
X\i_dline_16taps.dline_cells[9].genblk1.genblk1.i_dly_cell.i_sel_inv INVX1
+ $PINS Y=\i_dline_16taps.dline_cells[9].genblk1.genblk1.i_dly_cell.sel_n
+ VSS=VSS A=\i_dline_16taps.dline_cells[9].genblk1.genblk1.i_dly_cell.sel_i
+ VDD=VDD VNW=VDD VPW=VSS
Xi_fine_lsb_buf BUFX3 $PINS A=dline_out Y=dline_out_lsb_dly VDD=VDD VSS=VSS
+ VNW=VDD VPW=VSS
Xi_fine_lsb_mux MUXI2X1 $PINS A0=dline_out A1=dline_out_lsb_dly S0=delay_i[0]
+ VDD=VDD VSS=VSS Y=dline_out_noninv VNW=VDD VPW=VSS
.ENDS
